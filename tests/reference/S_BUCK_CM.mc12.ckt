* S_BUCK_CM.cir: MC12 12.2.0.5 File > Translate > Schematic to SPICE (Micro-Cap Spice, Transient+AC)
* Converted From Micro Cap Source file to MCAPSPICE
*
.FUNC DPWR(D) {I(D)*V(D)}
.FUNC BPWR(Q) {IC(Q)*VCE(Q)+IB(Q)*VBE(Q)}
.FUNC FPWR(M) {ID(M)*VDS(M)}
.FUNC HOTD(D,MAX) {IF((V(D)*I(D)>MAX),1,0)}
.FUNC HOTB(Q,MAX) {IF((VCE(Q)*IC(Q)+IB(Q)*VBE(Q)>MAX),1,0)}
.FUNC HOTF(M,MAX) {IF((VDS(M)*ID(M)>MAX),1,0)}
.PARAM LOW3MIN={IMPORT(LOW3MIN.OUT,LOW3THRES)}
.PARAM HIGH3MAX={IMPORT(HIGH3MAX.OUT,HIGH3THRES)}
.PARAM LOWLVDS={IMPORT(LOWLVDS.OUT,LOWLIMIT)}
.PARAM HILVDS={IMPORT(HILVDS.OUT,HILIMIT)}
.PARAM LIMTLVDS={IMPORT(LIMTLVDS.OUT,LVDSLIMITS)}
.FUNC SKINAC(DCRES,RESISTIVITY,RELPERM,RADIUS) {((PI*RADIUS*RADIUS)/((PI*RADIUS*RADIUS)-PI*(RADIUS-SKINDEPTHAC(RESISTIVITY,RELPERM))**2))*DCRES}
.FUNC SKINDEPTHAC(RESISTIVITY,RELPERM) {503.3*(SQRT(RESISTIVITY/(RELPERM*F)))}
.FUNC SKINTR(DCRES,RESISTIVITY,RELPERM,RADIUS,FREQ) {((PI*RADIUS*RADIUS)/((PI*RADIUS*RADIUS)-PI*(RADIUS-SKINDEPTHTR(RESISTIVITY,RELPERM,FREQ))**2))*DCRES}
.FUNC SKINDEPTHTR(RESISTIVITY,RELPERM,FREQ) {503.3*(SQRT(RESISTIVITY/(RELPERM*FREQ)))}
.PARAM REF=2.5V
.PARAM PERIOD=5U
.PARAM RATIO=1
.PARAM DUTYMAX=0.8
.PARAM RAMP=5V
.PARAM VOUTHI=15V
.PARAM VOUTLO=150M
.PARAM ROUT=10
.PARAM VHIGH=2.8
.PARAM ISINK=15M
.PARAM ISOURCE=500U
.PARAM VLOW=100M
.PARAM POLE=30
.PARAM GAIN=31622
C2 2 Verr 70P
C3 2 7 241P
C4 0 Vsense 470p
COUT Vout 13 727U IC=4.5
D1 0 Vrect DN5829
E1 Vcurrent 0 VALUE = {V(IN,SWITCH)}
L1 Vrect 11 9.33U
R1 11 Vout 4.5m
R6 0 2 12.94K
R7 7 Verr 220K
R8 Vsense Vcurrent 1K
R9 In Switch 193m
R11 2 Vout 12.94K
R12 3 Vsense 24.97K
RESR 0 13 16m
RLOAD 0 Vout 0.5
S1 Switch Vrect Vdrv 0 SW1
VIN In 0 DC 13
X1 Vdrv 0 Verr 2 Vsense 3 PWMCM
+PARAMS: REF={REF} PERIOD={PERIOD} DUTYMAX={DUTYMAX} RAMP={RAMP}
+ VOUTHI={VOUTHI} ROUT={ROUT} VHIGH={VHIGH} ISINK={ISINK} ISOURCE={ISOURCE}
+ VLOW={VLOW} POLE={POLE} GAIN={GAIN} VOUTLO={VOUTLO} RATIO={RATIO}
*
.MODEL SW1 VSWITCH (RON=10M VON=10 VOFF=1 ROFF=1E6)
.MODEL DN5829 D (IS=5.71E-04 N=1.25 BV=2.66E+01 IBV=8.5M
+ RS=3.75E-03 CJO=8.19E-09 VJ=.125 M=.426 XTI=2 EG=0.69 TT=1.80E-11)
*
*** From file C:\MC12\library\POWER456.LIB
.SUBCKT PWMCM 1   2   3    4  5	    6 	PARAMS:
*	          OUT GND COMP FB SENSE VOSC
+REF=2.5, PERIOD=5U, DUTYMAX=0.8, RAMP=5V, VOUTHI=15V,
+ROUT=10, VHIGH=3, ISINK=15M, ISOURCE=500U,
+VLOW=100M, POLE=30, GAIN=31622, VOUTLO=100M, RATIO=0.333
*
*	Generic Model for Current Mode PWM controller
*	Developed by Christophe BASSO, France
*	PSpice compatible format
*	Last modified: October 25th 1996
*
***** Generic PWM controller parameters *******
* REF 		; internal reference voltage
* PERIOD	; switching period
* DUTYMAX 	; maximum duty cycle
* RAMP		; ramp amplitude for compensation
* VOUTHI	; driver output voltage high
* VOUTLO	; driver output voltage low
* ROUT		; driver output resistor
***** Internal error amplifier parameters *****
* VHIGH		; maximum output voltage
* VLOW		; minimum output voltage
* ISINK		; sink capability
* ISOURCE	; source capability
* POLE		; first pole in Hertz
* GAIN		; DC open-loop gain (default=90dB)
* RATIO		; maximum peak current at max output error level
			; (CM only)
***********************************************

XERR 10 4 3 2 ERRAMP PARAMS:	VHIGH={VHIGH} ISINK={ISINK} ISOURCE={ISOURCE} ; error amplifier
+				VLOW={VLOW} POLE={POLE} GAIN={GAIN}

VREF 10 2 {REF}					; reference voltage

ELIM 500 2 VALUE = { V(3)*RATIO }				; max peak current = VOH*RATIO / Rsense

XCOM 5 500 12 COMP				; limit comparator

XFFL 11 82 14 13 FFLOP_800				; flip-flop

RDUM 13 2 1MEG
VCLK 11 2 PULSE 0 5 0 1N 1N 10N {PERIOD}	; Clock set pulses

VRAMP 6 2 PULSE 0 {RAMP} 0 {PERIOD-2N} 1N 1N {PERIOD}
VDUT 80 2 PULSE 0 5 {PERIOD*DUTYMAX} 1N 1N {(PERIOD-PERIOD*DUTYMAX)-2N} {PERIOD} ; max. duty cycle (=delay/period) delay=period-(tr+tf+tpuls)
XOR1 11 14 81 OR2_800				; Clock OR FFlopD

XOR2 80 12 82 OR2_800				; IMAX OR MAXduty Reset

E_BOUT 15 2 VALUE = { IF ( V(81) > 3.5, {VOUTHI}, {VOUTLO} ) }
ROUT 15 1 {ROUT}				; output resistor

.ENDS PWMCM
*
*** From file C:\MC12\library\POWER456.LIB
.SUBCKT ERRAMP 20 8  3  21 PARAMS: ISINK= 15M, ISOURCE=500U, VHIGH=2.8, VLOW=100M, POLE=30, GAIN=31622
*   	       +  - OUT GND

RIN 20 8 8MEG
CP1 11 21 {1/(6.28*(GAIN/100U)*POLE)}
E1 5 21 11 21 1
R9 5 2 5
D14 2 13 DMOD
IS 13 21 {ISINK/100}	; mA

Q1 21 13 16 QPMOD
ISRC 7 3 {ISOURCE}		; uA

D12 3 7 DMOD
D15 21 11 DCLAMP
G1 21 11 20 8 100U
V1 7 21 {VHIGH-0.6V}
V4 3 16 {VLOW-38MV}
RP1 11 21 {GAIN/100U}
.MODEL QPMOD PNP
.MODEL DCLAMP D (RS=10 BV=10 IBV=0.01)
.MODEL DMOD D (TT=1N CJO=10P)
.ENDS ERRAMP
*
*** From file C:\MC12\library\POWER456.LIB
.SUBCKT COMP 1 2 3
*            + - S
E_B1 4 0 VALUE = { IF ( V(1) > V(2), 5V, 0 ) }
RD 4 3 100
CD 3 0 10P
.ENDS COMP
*
*** From file C:\MC12\library\POWER456.LIB
.SUBCKT FFLOP_800 6 8 2 1
*             S R Q Q\
E_BQB 10 0 VALUE = { IF ( (V(8)<800M) & (V(2)>800M), 0, 5V ) }
E_BQ  20 0 VALUE = { IF ( (V(6)<800M) & (V(1)>800M), 0, 5V ) }
RD1   10 1 100
CD1   1 0 10P IC=5
RD2   20 2 100
CD2   2 0 10P IC=0
.ENDS FFLOP_800
*
*** From file C:\MC12\library\POWER456.LIB
.SUBCKT OR2_800 1 2 3
E_B1 4 0 VALUE = { IF ( (V(1)>800M) | (V(2)>800M), 5V, 0 ) }
RD 4 3 100
CD 3 0 10P
.ENDS OR2_800
*
.OPTIONS ACCT LIST OPTS ABSTOL=1pA CHGTOL=.01pC DEFL=100u DEFW=100u DEFNRD=0
+ DEFNRS=0 DEFPD=0 DEFPS=0 DIGDRVF=2 DIGDRVZ=20K DIGERRDEFAULT=20 DIGERRLIMIT=0
+ DIGFREQ=10GHz DIGINITSTATE=0 DIGIOLVL=2 DIGMNTYMX=2 DIGMNTYSCALE=0.4 DIGOVRDRV=3
+ DIGTYMXSCALE=1.6 DIODE_MAX_IS=1e-6 GMIN=1p INTERPOLATION_ORDER=2 ITL1=100
+ ITL2=50 ITL4=10 PIVREL=1m PIVTOL=.1p RELTOL=0.01 SANDH_PRECISION=1e-4 SD=2.58
+ SEED=0 TNOM=27 TRTOL=7 VNTOL=1u WIDTH=80 PRIVATEDIGITAL=0 PRIVATEANALOG
+ PERFORM_M=2 RMIN=1u R_NODE_GND=1e12 PATH_TO_GROUND VOLTAGE_LOOP_CHECK
+ FLOATING_NODES_CHECK=0 NUMERIC_DERIVATIVE=0 CSHUNT=0 RSHUNT=0 RP_FOR_ISOURCE=0
+ METHOD=GEAR
*
.LIB "C:\MC12\library\SMPS_CB.LIB"
*
.TEMP 27
*
.TRAN 5e-006 250u 0 50n UIC
.PLOT TRAN I(L1) 8,12
.PLOT TRAN V(VSENSE) 0,2.5
*
.AC LIN 11 0 0
*
.END
;$SpiceType=MCAPSPICE
