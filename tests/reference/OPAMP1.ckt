* OPAMP1.cir: MC12 12.2.0.5 File > Translate > Schematic to SPICE (Micro-Cap Spice, Transient+AC)
* Converted From Micro Cap Source file to MCAPSPICE
*
.FUNC DPWR(D) {I(D)*V(D)}
.FUNC BPWR(Q) {IC(Q)*VCE(Q)+IB(Q)*VBE(Q)}
.FUNC FPWR(M) {ID(M)*VDS(M)}
.FUNC HOTD(D,MAX) {IF((V(D)*I(D)>MAX),1,0)}
.FUNC HOTB(Q,MAX) {IF((VCE(Q)*IC(Q)+IB(Q)*VBE(Q)>MAX),1,0)}
.FUNC HOTF(M,MAX) {IF((VDS(M)*ID(M)>MAX),1,0)}
.PARAM LOW3MIN={IMPORT(LOW3MIN.OUT,LOW3THRES)}
.PARAM HIGH3MAX={IMPORT(HIGH3MAX.OUT,HIGH3THRES)}
.PARAM LOWLVDS={IMPORT(LOWLVDS.OUT,LOWLIMIT)}
.PARAM HILVDS={IMPORT(HILVDS.OUT,HILIMIT)}
.PARAM LIMTLVDS={IMPORT(LIMTLVDS.OUT,LVDSLIMITS)}
.FUNC SKINAC(DCRES,RESISTIVITY,RELPERM,RADIUS) {((PI*RADIUS*RADIUS)/((PI*RADIUS*RADIUS)-PI*(RADIUS-SKINDEPTHAC(RESISTIVITY,RELPERM))**2))*DCRES}
.FUNC SKINDEPTHAC(RESISTIVITY,RELPERM) {503.3*(SQRT(RESISTIVITY/(RELPERM*F)))}
.FUNC SKINTR(DCRES,RESISTIVITY,RELPERM,RADIUS,FREQ) {((PI*RADIUS*RADIUS)/((PI*RADIUS*RADIUS)-PI*(RADIUS-SKINDEPTHTR(RESISTIVITY,RELPERM,FREQ))**2))*DCRES}
.FUNC SKINDEPTHTR(RESISTIVITY,RELPERM,FREQ) {503.3*(SQRT(RESISTIVITY/(RELPERM*FREQ)))}
V1 2 0 DC 15
V2 0 4 DC 15
V3 5 0 DC 15
V4 0 6 DC 15
V5 7 0 DC 15
V6 0 1 DC 15
VPULSE In 0 AC 1 DC -10 PULSE (-10 10 1e-006 1e-008 1e-008 3.99e-006 1e-005)
XO1 In Out1 1 Out1 2 O1
XO2 In Out2 4 Out2 5 O2
XO3 In Out3 6 Out3 7 O3
*
* OPAMP
* PINS:  1=NC+ 2=NC- 3=VEE 4=VO 5=VCC
.SUBCKT O1 1 2 3 4 5
RSUPPLUS 5 0 1
RSUPMIN  3 0 1
ROUT 4 0 125
GOUT 0 4 1 2 8000
RIN 1 2 1G
.ENDS O1
*
* OPAMP
* PINS:  1=NC+ 2=NC- 3=VEE 4=VO 5=VCC
.SUBCKT O2 1 2 3 4 5
RSUPPLUS 5 0 1
RSUPMIN  3 0 1
C1 6 0 0.0002546479089470325
R1 6 0 125
G1 0 6 TABLE {V(1,2)} = (-0.09549296585513727,-0.0763943726841098)
+ (0.1273239544735164,0.1018591635788131)
C2 7 0 1.470213783098858e-010
R2 7 0 125
G2 0 7 6 0 0.7999999999999998
ROUT 4 0 125
GOUT 0 4 7 0 0.7999999999999998
RIN 1 2 1G
.ENDS O2
*
* OPAMP
* PINS:  1=NC+ 2=NC- 3=VEE 4=VO 5=VCC
.SUBCKT O3 1 2 3 4 5
IEE 10 3 0.0001216
VS1 11 0 0
VC 5 16 3
VE 17 3 3
VLP 19 0 25
VLN 0 20 25
VS2 13 15 0
F1 13 14 POLY(5) VS1 VC VE VLP VLN 0 42441318.15783875 -42441318.15783875
+ 42441318.15783875 42441318.15783875 -42441318.15783875
E1 14 0 POLY(2) 5 0 3 0   0 0.5 0.5
H1 18 0 VS2 1000
GCM 0 12 10 0   9.424777960769381e-012
GA 12 0 6 7   0.0009424777960769381
C1 6 7 8.660254037844386e-012
CE 10 14 1e-011
C2 12 13 3e-011
RC1 5 6 1061.032953945969
RC2 5 7 1061.032953945969
RE1 8 10 621.6741916481359
RE2 9 10 621.6741916481359
RE 10 14 1644736.842105263
RP 5 3 3653.309086185621
R2 12 11 100000
RO2 13 14 25
ROUTAC 15 4 50
D5 3 5 D
D3 4 16 D
D4 17 4 D
D1 18 19 D
D2 20 18 D
Q1 6 2 8 QINN
Q2 7 1 9 QINP
*
.MODEL D D ()
.MODEL QINN NPN (BF=75)
.MODEL QINP NPN (BF=75 IS=1e-016)
.ENDS O3
*
.OPTIONS ACCT LIST OPTS ABSTOL=1pA CHGTOL=.01pC DEFL=100u DEFW=100u DEFNRD=0
+ DEFNRS=0 DEFPD=0 DEFPS=0 DIGDRVF=2 DIGDRVZ=20K DIGERRDEFAULT=20 DIGERRLIMIT=0
+ DIGFREQ=10GHz DIGINITSTATE=0 DIGIOLVL=2 DIGMNTYMX=2 DIGMNTYSCALE=0.4 DIGOVRDRV=3
+ DIGTYMXSCALE=1.6 DIODE_MAX_IS=1e-6 GMIN=1p INTERPOLATION_ORDER=2 ITL1=100
+ ITL2=50 ITL4=10 PIVREL=1m PIVTOL=.1p RELTOL=1m SANDH_PRECISION=1e-4 SD=2.58
+ SEED=0 TNOM=27 TRTOL=7 VNTOL=1u WIDTH=80 PRIVATEDIGITAL=0 PRIVATEANALOG
+ PERFORM_M=2 RMIN=1u R_NODE_GND=1e12 PATH_TO_GROUND VOLTAGE_LOOP_CHECK
+ FLOATING_NODES_CHECK=0 NUMERIC_DERIVATIVE=0 CSHUNT=0 RSHUNT=0 RP_FOR_ISOURCE=0
+ METHOD=TRAP
*
*
.TEMP 27
*
.TRAN 2.04082e-007 10u 0 10n
.PLOT TRAN V(IN) V(OUT1) V(OUT2) V(OUT3) -15,15
*
.AC DEC 40 1e4 1E9
.PLOT AC db(V(OUT1)) db(V(OUT2)) db(V(OUT3)) -80,20
*
.END
;$SpiceType=MCAPSPICE
