V_PULSE IN 0 PULSE(-10 10 1u 10n 10n 3.99u 10u)
XO1 IN O1 NEG1 O1 POS1 OPA1
V6 0 NEG1 15
V1 POS1 0 15
XO2 IN O2 NEG2 O2 POS2 OPA2
V2 0 NEG2 15
V3 POS2 0 15
XO3 IN O3 NEG3 O3 POS3 OPA3
V4 0 NEG3 15
V5 POS3 0 15
.END
