* MOSDIFF.cir: MC12 12.2.0.5 File > Translate > Schematic to SPICE (Micro-Cap Spice, Transient+AC)
* Converted From Micro Cap Source file to MCAPSPICE
*
.FUNC DPWR(D) {I(D)*V(D)}
.FUNC BPWR(Q) {IC(Q)*VCE(Q)+IB(Q)*VBE(Q)}
.FUNC FPWR(M) {ID(M)*VDS(M)}
.FUNC HOTD(D,MAX) {IF((V(D)*I(D)>MAX),1,0)}
.FUNC HOTB(Q,MAX) {IF((VCE(Q)*IC(Q)+IB(Q)*VBE(Q)>MAX),1,0)}
.FUNC HOTF(M,MAX) {IF((VDS(M)*ID(M)>MAX),1,0)}
.PARAM LOW3MIN={IMPORT(LOW3MIN.OUT,LOW3THRES)}
.PARAM HIGH3MAX={IMPORT(HIGH3MAX.OUT,HIGH3THRES)}
.PARAM LOWLVDS={IMPORT(LOWLVDS.OUT,LOWLIMIT)}
.PARAM HILVDS={IMPORT(HILVDS.OUT,HILIMIT)}
.PARAM LIMTLVDS={IMPORT(LIMTLVDS.OUT,LVDSLIMITS)}
.FUNC SKINAC(DCRES,RESISTIVITY,RELPERM,RADIUS) {((PI*RADIUS*RADIUS)/((PI*RADIUS*RADIUS)-PI*(RADIUS-SKINDEPTHAC(RESISTIVITY,RELPERM))**2))*DCRES}
.FUNC SKINDEPTHAC(RESISTIVITY,RELPERM) {503.3*(SQRT(RESISTIVITY/(RELPERM*F)))}
.FUNC SKINTR(DCRES,RESISTIVITY,RELPERM,RADIUS,FREQ) {((PI*RADIUS*RADIUS)/((PI*RADIUS*RADIUS)-PI*(RADIUS-SKINDEPTHTR(RESISTIVITY,RELPERM,FREQ))**2))*DCRES}
.FUNC SKINDEPTHTR(RESISTIVITY,RELPERM,FREQ) {503.3*(SQRT(RESISTIVITY/(RELPERM*FREQ)))}
M1 5 6 7 4 Q1
M2 10 1 7 4 Q1
M3 6 0 3 4 Q1
M4 3 9 4 4 Q2
M5 9 9 4 4 Q2
M6 4 9 7 4 Q2
M7 1 2 3 4 Q1
R1 8 5 10K
R2 8 6 10K
R3 8 10 10K
R4 8 1 10K
R5 8 9 20K
V1 0 4 DC 15V
V2 8 0 DC 15V
VSTEP 2 0 AC 1 DC 0 PULSE (0 0.001 1e-007 1e-007 1e-007 2.4e-006 5e-006)
*
.MODEL Q2 NMOS (LEVEL=1 VTO=2 KP=2M L=100U W=100U GAMMA=500M
+LAMBDA=1M CGSO=40P CGDO=40P CGBO=200P MJSW=333M TOX=100N NSUB=1000T
+NSS=10G NFS=10G XJ=0 LD=0 XQC=0 FC=500M KAPPA=0)
.MODEL Q1 NMOS (LEVEL=1 VTO=2 KP=20M L=100U W=100U GAMMA=500M
+CGSO=40P CGDO=40P CGBO=200P MJSW=333M TOX=100N NSUB=1000T NSS=10G
+NFS=10G XJ=0 LD=0 XQC=0 FC=500M KAPPA=0)
*
.OPTIONS ACCT LIST OPTS ABSTOL=1pA CHGTOL=.01pC DEFL=100u DEFW=100u DEFNRD=0
+ DEFNRS=0 DEFPD=0 DEFPS=0 DIGDRVF=2 DIGDRVZ=20K DIGERRDEFAULT=20 DIGERRLIMIT=0
+ DIGFREQ=10GHz DIGINITSTATE=0 DIGIOLVL=2 DIGMNTYMX=2 DIGMNTYSCALE=0.4 DIGOVRDRV=3
+ DIGTYMXSCALE=1.6 DIODE_MAX_IS=1e-6 GMIN=1p INTERPOLATION_ORDER=2 ITL1=100
+ ITL2=50 ITL4=10 PIVREL=1m PIVTOL=.1p RELTOL=1m SANDH_PRECISION=1e-4 SD=2.58
+ SEED=0 TNOM=27 TRTOL=7 VNTOL=1u WIDTH=80 PRIVATEDIGITAL=0 PRIVATEANALOG
+ PERFORM_M=2 RMIN=1u R_NODE_GND=1e12 PATH_TO_GROUND VOLTAGE_LOOP_CHECK
+ FLOATING_NODES_CHECK=0 NUMERIC_DERIVATIVE=0 CSHUNT=0 RSHUNT=0 RP_FOR_ISOURCE=0
+ METHOD=TRAP
*
*
.TEMP 27
*
.TRAN 1.02041e-007 5E-6 0 1e-007
.PLOT TRAN V(2) 0,0.0015
.PLOT TRAN V(1,6) -0.06,0.004
.PLOT TRAN V(10,5) -0.5,3
.PLOT TRAN V(10) 8,10
*
.AC LIN 49 1E4 1E9
.NOISE V(5) VSTEP 10

.PLOT NOISE DB(INOISE) DB(ONOISE) -200,-100
*
.END
;$SpiceType=MCAPSPICE
