V1 IN 0 DC 0 AC 1 0
R1 IN OUT 1k
C1 OUT 0 100n
.END
