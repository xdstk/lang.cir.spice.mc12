* BAX.cir: MC12 12.2.0.5 File > Translate > Schematic to SPICE (Micro-Cap Spice, Transient+AC)
* Converted From Micro Cap Source file to MCAPSPICE
*
.FUNC DPWR(D) {I(D)*V(D)}
.FUNC BPWR(Q) {IC(Q)*VCE(Q)+IB(Q)*VBE(Q)}
.FUNC FPWR(M) {ID(M)*VDS(M)}
.FUNC HOTD(D,MAX) {IF((V(D)*I(D)>MAX),1,0)}
.FUNC HOTB(Q,MAX) {IF((VCE(Q)*IC(Q)+IB(Q)*VBE(Q)>MAX),1,0)}
.FUNC HOTF(M,MAX) {IF((VDS(M)*ID(M)>MAX),1,0)}
.PARAM LOW3MIN={IMPORT(LOW3MIN.OUT,LOW3THRES)}
.PARAM HIGH3MAX={IMPORT(HIGH3MAX.OUT,HIGH3THRES)}
.PARAM LOWLVDS={IMPORT(LOWLVDS.OUT,LOWLIMIT)}
.PARAM HILVDS={IMPORT(HILVDS.OUT,HILIMIT)}
.PARAM LIMTLVDS={IMPORT(LIMTLVDS.OUT,LVDSLIMITS)}
.FUNC SKINAC(DCRES,RESISTIVITY,RELPERM,RADIUS) {((PI*RADIUS*RADIUS)/((PI*RADIUS*RADIUS)-PI*(RADIUS-SKINDEPTHAC(RESISTIVITY,RELPERM))**2))*DCRES}
.FUNC SKINDEPTHAC(RESISTIVITY,RELPERM) {503.3*(SQRT(RESISTIVITY/(RELPERM*F)))}
.FUNC SKINTR(DCRES,RESISTIVITY,RELPERM,RADIUS,FREQ) {((PI*RADIUS*RADIUS)/((PI*RADIUS*RADIUS)-PI*(RADIUS-SKINDEPTHTR(RESISTIVITY,RELPERM,FREQ))**2))*DCRES}
.FUNC SKINDEPTHTR(RESISTIVITY,RELPERM,FREQ) {503.3*(SQRT(RESISTIVITY/(RELPERM*FREQ)))}
C1 1 5 100N
C2 4 3 3N
C3 5 7 100N
R1 1 5 10
R2 5 7 {10K-R(R1)}
R3 5 4 10K
R4 In1 7 1K
R5 In1 3 11K
R6 1 Vout 1K
R7 3 Vout 11K
R8 Vout 0 10K
V1 0 9 DC 15
V2 8 0 DC 15
V3 INTERIOR_NONE1 0 AC 1 SIN (0 1 200 0 0 0)
RV3 In1 INTERIOR_NONE1 0.001 ;added by V3
XLF351 0 4 9 Vout 8 LF351
*
* OPAMP
* PINS:  1=NC+ 2=NC- 3=VEE 4=VO 5=VCC
.SUBCKT LF351 1 2 3 4 5
IEE 10 3 1.52e-005
VS1 11 0 0
VC 5 16 2
VE 17 3 2
VLP 19 0 20
VLN 0 20 20
VS2 13 15 0
F1 13 14 POLY(5) VS1 VC VE VLP VLN 0 21220659.07891938 -21220659.07891938
+ 21220659.07891938 21220659.07891938 -21220659.07891938
E1 14 0 POLY(2) 5 0 3 0   0 0.5 0.5
H1 18 0 VS2 1000
GCM 0 12 10 0   1.884955592153876e-009
GA 12 0 6 7   0.0001884955592153876
C1 6 7 8.660254037844386e-012
CE 10 14 1e-019
C2 12 13 3e-011
RC1 5 6 5305.164769729845
RC2 5 7 5305.164769729845
RE1 8 10 1832.178153798389
RE2 9 10 1832.178153798389
RE 10 14 13157894.7368421
RP 5 3 36668.83963494133
R2 12 11 100000
RO2 13 14 50
ROUTAC 15 4 75
D5 3 5 D
D3 4 16 D
D4 17 4 D
D1 18 19 D
D2 20 18 D
Q1 6 2 8 QINN
Q2 7 1 9 QINP
*
.MODEL D D ()
.MODEL QINN NPN (BF=74.6268656716418)
.MODEL QINP NPN (BF=75.37688442211055 IS=1e-016)
.ENDS LF351
*
.OPTIONS ACCT LIST OPTS ABSTOL=1pA CHGTOL=.01pC DEFL=100u DEFW=100u DEFNRD=0
+ DEFNRS=0 DEFPD=0 DEFPS=0 DIGDRVF=2 DIGDRVZ=20K DIGERRDEFAULT=20 DIGERRLIMIT=0
+ DIGFREQ=10GHz DIGINITSTATE=0 DIGIOLVL=2 DIGMNTYMX=2 DIGMNTYSCALE=0.4 DIGOVRDRV=3
+ DIGTYMXSCALE=1.6 DIODE_MAX_IS=1e-6 GMIN=1p INTERPOLATION_ORDER=2 ITL1=100
+ ITL2=50 ITL4=10 PIVREL=1m PIVTOL=.1p RELTOL=1m SANDH_PRECISION=1e-4 SD=2.58
+ SEED=0 TNOM=27 TRTOL=7 VNTOL=1u WIDTH=80 PRIVATEDIGITAL=0 PRIVATEANALOG
+ PERFORM_M=2 RMIN=1u R_NODE_GND=1e12 PATH_TO_GROUND VOLTAGE_LOOP_CHECK
+ FLOATING_NODES_CHECK=0 NUMERIC_DERIVATIVE=0 CSHUNT=0 RSHUNT=0 RP_FOR_ISOURCE=0
+ METHOD=TRAP
*
*
.TEMP 27
*
.TRAN 0.0004 .02 0 .1m
.PLOT TRAN v(IN1) -1.2,1.2
.PLOT TRAN v(VOUT) -4,4
.if analysis=_TRANSIENT
.STEP LIN R1 0 9k 1000 ;$MCE Value;Transient Analysis
.endif
*
.AC LIN 49 20 20k
.PLOT AC dB(mag(v(VOUT)/v(IN1))) -40,40
.if analysis=_AC
.STEP LIN R1 0 9k 1000 ;$MCE Value;AC Analysis
.endif
*
.END
;$SpiceType=MCAPSPICE
