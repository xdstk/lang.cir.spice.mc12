* Sallen-Key_High_Pass_Filter.cir: MC12 12.2.0.5 File > Translate > Schematic to SPICE (Micro-Cap Spice, Transient+AC)
* Converted From Micro Cap Source file to MCAPSPICE
*
.FUNC DPWR(D) {I(D)*V(D)}
.FUNC BPWR(Q) {IC(Q)*VCE(Q)+IB(Q)*VBE(Q)}
.FUNC FPWR(M) {ID(M)*VDS(M)}
.FUNC HOTD(D,MAX) {IF((V(D)*I(D)>MAX),1,0)}
.FUNC HOTB(Q,MAX) {IF((VCE(Q)*IC(Q)+IB(Q)*VBE(Q)>MAX),1,0)}
.FUNC HOTF(M,MAX) {IF((VDS(M)*ID(M)>MAX),1,0)}
.PARAM LOW3MIN={IMPORT(LOW3MIN.OUT,LOW3THRES)}
.PARAM HIGH3MAX={IMPORT(HIGH3MAX.OUT,HIGH3THRES)}
.PARAM LOWLVDS={IMPORT(LOWLVDS.OUT,LOWLIMIT)}
.PARAM HILVDS={IMPORT(HILVDS.OUT,HILIMIT)}
.PARAM LIMTLVDS={IMPORT(LIMTLVDS.OUT,LVDSLIMITS)}
.FUNC SKINAC(DCRES,RESISTIVITY,RELPERM,RADIUS) {((PI*RADIUS*RADIUS)/((PI*RADIUS*RADIUS)-PI*(RADIUS-SKINDEPTHAC(RESISTIVITY,RELPERM))**2))*DCRES}
.FUNC SKINDEPTHAC(RESISTIVITY,RELPERM) {503.3*(SQRT(RESISTIVITY/(RELPERM*F)))}
.FUNC SKINTR(DCRES,RESISTIVITY,RELPERM,RADIUS,FREQ) {((PI*RADIUS*RADIUS)/((PI*RADIUS*RADIUS)-PI*(RADIUS-SKINDEPTHTR(RESISTIVITY,RELPERM,FREQ))**2))*DCRES}
.FUNC SKINDEPTHTR(RESISTIVITY,RELPERM,FREQ) {503.3*(SQRT(RESISTIVITY/(RELPERM*FREQ)))}
C1 5 4 1n
C2 6 4 1n
R1 Out 4 Rmod 18.2K
R3 0 6 Rmod 14K
R4 Out 7 Rmod 10K
R5 0 7 Rmod 10K
V1 Vp 0 DC 12
V2 Vn 0 DC -12
V3 5 0 DC 0 AC 1 0 Sin 0 1 1k 0 0 0
X1 6 7 Vp Vn Out AD711K_AD
*
.MODEL RMOD RES (R=1 LOT=1%)
*
*** From file C:\MC12\library\ANALOG.LIB
.SUBCKT AD711K_AD 13 15 12 16 14
*
VOS 15 8 DC 0.5E-3
EC 9 0 (14,0) 1
C1 6 7 .5E-12
RP 16 12 10.35E3
GB 11 0 (3,0) 1.67E3
RD1 6 16 16E3
RD2 7 16 16E3
ISS 12 1 DC 100E-6
CCI 3 11 45E-12
GCM 0 3 (0,1) 1.76E-9
GA 3 0 (7,6) 780E-6
RE 1 0 2.5E6
RGM 3 0 2.6E3
VC 12 2 DC 2.8
VE 10 16 DC 3.1
RO1 11 14 25
CE 1 0 2E-12
RO2 0 11 30
RS1 1 4 5.77E3
RS2 1 5 5.77E3
J1 6 13 4 FET
J2 7 8 5 FET
DC 14 2 DIODE
DE 10 14 DIODE
DP 16 12 DIODE
D1 9 11 DIODE
D2 11 9 DIODE
IOS 15 13 12.5E-12
.MODEL DIODE D()
.MODEL FET PJF(VTO=-1 BETA=1E-3 IS=50E-12)
.ENDS
*
.OPTIONS ACCT LIST OPTS ABSTOL=1pA CHGTOL=.01pC DEFL=100u DEFW=100u DEFNRD=0
+ DEFNRS=0 DEFPD=0 DEFPS=0 DIGDRVF=2 DIGDRVZ=20K DIGERRDEFAULT=20 DIGERRLIMIT=0
+ DIGFREQ=10GHz DIGINITSTATE=0 DIGIOLVL=2 DIGMNTYMX=2 DIGMNTYSCALE=0.4 DIGOVRDRV=3
+ DIGTYMXSCALE=1.6 DIODE_MAX_IS=1e-6 GMIN=1p INTERPOLATION_ORDER=2 ITL1=100
+ ITL2=50 ITL4=10 PIVREL=1m PIVTOL=.1p RELTOL=1m SANDH_PRECISION=1e-4 SD=2.58
+ SEED=0 TNOM=27 TRTOL=7 VNTOL=1u WIDTH=80 PRIVATEDIGITAL=0 PRIVATEANALOG
+ PERFORM_M=2 RMIN=1u R_NODE_GND=1e12 PATH_TO_GROUND VOLTAGE_LOOP_CHECK
+ FLOATING_NODES_CHECK=0 NUMERIC_DERIVATIVE=0 CSHUNT=0 RSHUNT=0 RP_FOR_ISOURCE=0
+ METHOD=TRAP
*
*
.TEMP 27
*
.TRAN 2e-008 1u 0
*
.AC DEC 167 1 1Meg
.PLOT AC dB(V(OUT)) -160,20
.PLOT AC ph(V(OUT)) -60,240
*
.END
;$SpiceType=MCAPSPICE
