* hand reference
V3 IN 0 DC 0 AC 1
C1 IN A 1n
C2 A PLUS 1n
R1 A OUT 18.2k
R3 PLUS 0 14k
R4 MINUS OUT 10k
R5 MINUS 0 10k
X1 PLUS MINUS VCC VEE OUT AD711K_AD
V1 VCC 0 12
V2 VEE 0 -12
.END
