* CHOKE.cir: MC12 12.2.0.5 File > Translate > Schematic to SPICE (Micro-Cap Spice, Transient+AC)
* Converted From Micro Cap Source file to MCAPSPICE
*
.FUNC DPWR(D) {I(D)*V(D)}
.FUNC BPWR(Q) {IC(Q)*VCE(Q)+IB(Q)*VBE(Q)}
.FUNC FPWR(M) {ID(M)*VDS(M)}
.FUNC HOTD(D,MAX) {IF((V(D)*I(D)>MAX),1,0)}
.FUNC HOTB(Q,MAX) {IF((VCE(Q)*IC(Q)+IB(Q)*VBE(Q)>MAX),1,0)}
.FUNC HOTF(M,MAX) {IF((VDS(M)*ID(M)>MAX),1,0)}
.PARAM LOW3MIN={IMPORT(LOW3MIN.OUT,LOW3THRES)}
.PARAM HIGH3MAX={IMPORT(HIGH3MAX.OUT,HIGH3THRES)}
.PARAM LOWLVDS={IMPORT(LOWLVDS.OUT,LOWLIMIT)}
.PARAM HILVDS={IMPORT(HILVDS.OUT,HILIMIT)}
.PARAM LIMTLVDS={IMPORT(LIMTLVDS.OUT,LVDSLIMITS)}
.FUNC SKINAC(DCRES,RESISTIVITY,RELPERM,RADIUS) {((PI*RADIUS*RADIUS)/((PI*RADIUS*RADIUS)-PI*(RADIUS-SKINDEPTHAC(RESISTIVITY,RELPERM))**2))*DCRES}
.FUNC SKINDEPTHAC(RESISTIVITY,RELPERM) {503.3*(SQRT(RESISTIVITY/(RELPERM*F)))}
.FUNC SKINTR(DCRES,RESISTIVITY,RELPERM,RADIUS,FREQ) {((PI*RADIUS*RADIUS)/((PI*RADIUS*RADIUS)-PI*(RADIUS-SKINDEPTHTR(RESISTIVITY,RELPERM,FREQ))**2))*DCRES}
.FUNC SKINDEPTHTR(RESISTIVITY,RELPERM,FREQ) {503.3*(SQRT(RESISTIVITY/(RELPERM*FREQ)))}
C1 0 B 2UF
D1 3 A D0
D2 1 A D0
L1 B A 5
R1 0 B 10K
R2 0 A 10K
V1 INTERIOR_NONE1 0 AC 1 SIN (0 100 50 0 0 0)
RV1 1 INTERIOR_NONE1 0.001 ;added by V1
V2 INTERIOR_NONE2 3 AC 1 SIN (0 100 50 0 0 0)
RV2 0 INTERIOR_NONE2 0.001 ;added by V2
*
.MODEL D0 D (IS=10F CJO=10P)
*
.OPTIONS ACCT LIST OPTS ABSTOL=1pA CHGTOL=.01pC DEFL=100u DEFW=100u DEFNRD=0
+ DEFNRS=0 DEFPD=0 DEFPS=0 DIGDRVF=2 DIGDRVZ=20K DIGERRDEFAULT=20 DIGERRLIMIT=0
+ DIGFREQ=10GHz DIGINITSTATE=0 DIGIOLVL=2 DIGMNTYMX=2 DIGMNTYSCALE=0.4 DIGOVRDRV=3
+ DIGTYMXSCALE=1.6 DIODE_MAX_IS=1e-6 GMIN=1p INTERPOLATION_ORDER=2 ITL1=100
+ ITL2=50 ITL4=10 PIVREL=1m PIVTOL=.1p RELTOL=1m SANDH_PRECISION=1e-4 SD=2.58
+ SEED=0 TNOM=27 TRTOL=7 VNTOL=1u WIDTH=80 PRIVATEDIGITAL=0 PRIVATEANALOG
+ PERFORM_M=2 RMIN=1u R_NODE_GND=1e12 PATH_TO_GROUND VOLTAGE_LOOP_CHECK
+ FLOATING_NODES_CHECK=0 NUMERIC_DERIVATIVE=0 CSHUNT=0 RSHUNT=0 RP_FOR_ISOURCE=0
+ METHOD=TRAP
*
*
.TEMP 27
*
.TRAN 0.00263158 50m 0 .2M
.PLOT TRAN V(A) V(B) 0,200
*
.AC LIN 49 1E6 1E8
*
.END
;$SpiceType=MCAPSPICE
