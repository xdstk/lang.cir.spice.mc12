* RC low-pass probe: R=1k C=100n, fc=1591.5 Hz
V1 IN 0 DC 0 AC 1
R1 IN OUT 1K
C1 OUT 0 100N
.AC DEC 101 10 1MEG
.PRINT AC VDB(OUT) VP(OUT)
.TRAN 10U 2M
.PRINT TRAN V(IN) V(OUT)
.END
